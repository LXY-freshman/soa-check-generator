simulator lang=spectre
subckt demo_nmos (d g s b)
M0 (d g s b) nmos w=10u l=0.18u nf=2 m=1
ends demo_nmos
subckt demo_pmos (d g s b)
M0 (d g s b) pmos w=4u nf=3
ends demo_pmos
