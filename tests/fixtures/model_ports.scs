simulator lang=spectre
inline subckt demo_mos_mid_isowell_30v_ckt (d g s b nbl psub)
inline subckt demo_pmos_mid_isowell_7v_7t_mac (d g s b pepi nbl psub)
check_iso assert subs=demo_mos_mid_isowell_30v_ckt expr="V(nbl,psub)" max=30 level=warning
